* PEX psrr corner=fs S1=1.8 S0=0
.lib /foss/pdks/sky130A/libs.tech/combined/sky130.lib.spice fs
.include /headless/Desktop/BGR_Shayem/BGR_NSL_Final/BGR_NSL/BGR_TOP_SKY130A/BGR_TOP_pex.spice
.temp 27
Vsup vdd 0 DC 1.8 AC 1
Vgnd vss 0 DC 0
Vsel0 S0 0 DC 0
Vsel1 S1 0 DC 1.8
Xdut S0 S1 out vdd vss S1 BGR_TOP
.control
ac dec 20 1 1G
let psrr = -vdb(out)
wrdata /headless/Desktop/BGR_Shayem/BGR_NSL_Final/BGR_NSL/BGR_TOP_SKY130A/results/work/psrr_S1_1.8_S0_0_fs.txt psrr
.endc
.end
