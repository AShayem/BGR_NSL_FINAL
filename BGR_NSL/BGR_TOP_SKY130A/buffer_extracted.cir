* Extracted by KLayout with SKY130 LVS runset on : 29/10/2026 06:19

* cell buffer
* pin sky130_gnd
.SUBCKT buffer sky130_gnd
* device instance $1 r0 *1 1.47,5.26 sky130_fd_pr__pfet_01v8_lvt
XM$1 \$3 \$44 \$1 \$3 sky130_fd_pr__pfet_01v8_lvt L=1000000 W=8000000
+ AS=3.3e+12 AD=2.64e+12 PS=13300000 PD=10640000
* device instance $5 r0 *1 8.11,5.26 sky130_fd_pr__pfet_01v8_lvt
XM$5 \$3 \$1 \$2 \$3 sky130_fd_pr__pfet_01v8_lvt L=1000000 W=16000000
+ AS=5.28e+12 AD=5.94e+12 PS=21280000 PD=23940000
* device instance $13 r0 *1 1.47,1.7 sky130_fd_pr__nfet_01v8_lvt
XM$13 sky130_gnd \$44 \$1 sky130_gnd sky130_fd_pr__nfet_01v8_lvt L=1000000
+ W=4000000 AS=1.65e+12 AD=1.32e+12 PS=8300000 PD=6640000
* device instance $17 r0 *1 8.11,1.7 sky130_fd_pr__nfet_01v8_lvt
XM$17 sky130_gnd \$1 \$2 sky130_gnd sky130_fd_pr__nfet_01v8_lvt L=1000000
+ W=8000000 AS=2.64e+12 AD=2.97e+12 PS=13280000 PD=14940000
.ENDS buffer
